; Example Bindkeys for Layout Productivity
hiSetBindKeys( "Layout" list(
		list("None<Key>`"
			"leSetEntryLayer( list(\"POLY1\" \"drawing\"))
			leSetLayerVisible(list(\"POLY1\" \"drawing\") t)
			leSetLayerVisible(list(\"POLY1\" \"dummy\") t)
			leSetLayerVisible(list(\"POLY1\" \"pin\") t)
			leSetLayerVisible(list(\"PIMP\" \"drawing\") t)
			leSetLayerVisible(list(\"NIMP\" \"drawing\") t)
			leSetLayerVisible(list(\"DIFF\" \"drawing\") t)
			leSetLayerVisible(list(\"DIFF\" \"dummy\") t)
			leSetLayerVisible(list(\"CONT\" \"drawing\") t)
			leSetLayerVisible(list(\"NWELL\" \"drawing\") t)
			leSetLayerVisible(list(\"WELLBODY\" \"drawing\") t)
			hiRedraw()")
		list("None<Key>1"
			"leSetEntryLayer( list(\"METAL1\" \"drawing\"))
			leSetLayerVisible(list(\"METAL1\" \"drawing\") t)
			leSetLayerVisible(list(\"METAL1\" \"pin\") t)
			leSetLayerVisible(list(\"METAL1\" \"dummy\") t)
			leSetLayerVisible(list(\"CONT\" \"drawing\") t)
			leSetLayerVisible(list(\"VIA12\" \"drawing\") t)
			hiRedraw()")
		list("None<Key>2"
			"leSetEntryLayer( list(\"METAL2\" \"drawing\"))
			leSetLayerVisible(list(\"METAL2\" \"drawing\") t)
			leSetLayerVisible(list(\"METAL2\" \"pin\") t)
			leSetLayerVisible(list(\"METAL2\" \"dummy\") t)
			leSetLayerVisible(list(\"VIA12\" \"drawing\") t)
			leSetLayerVisible(list(\"VIA23\" \"drawing\") t)
			hiRedraw()")
		list("None<Key>3"
			"leSetEntryLayer( list(\"METAL3\" \"drawing\"))
			leSetLayerVisible(list(\"METAL3\" \"drawing\") t)
			leSetLayerVisible(list(\"METAL3\" \"pin\") t)
			leSetLayerVisible(list(\"METAL3\" \"dummy\") t)
			leSetLayerVisible(list(\"VIA23\" \"drawing\") t)
			leSetLayerVisible(list(\"VIA34\" \"drawing\") t)
			hiRedraw()")
		list("None<Key>4"
			"leSetEntryLayer( list(\"METAL4\" \"drawing\"))
			leSetLayerVisible(list(\"METAL4\" \"drawing\") t)
			leSetLayerVisible(list(\"METAL4\" \"pin\") t)
			leSetLayerVisible(list(\"METAL4\" \"dummy\") t)
			leSetLayerVisible(list(\"VIA34\" \"drawing\") t)
			leSetLayerVisible(list(\"VIA45\" \"drawing\") t)
			hiRedraw()")
		list("None<Key>5"
			"leSetEntryLayer( list(\"METAL5\" \"drawing\"))
			leSetLayerVisible(list(\"METAL5\" \"drawing\") t)
			leSetLayerVisible(list(\"METAL5\" \"pin\") t)
			leSetLayerVisible(list(\"METAL5\" \"dummy\") t)
			leSetLayerVisible(list(\"VIA45\" \"drawing\") t)
			leSetLayerVisible(list(\"VIA56\" \"drawing\") t)
			hiRedraw()")
		list("None<Key>6"
			"leSetEntryLayer( list(\"METAL6\" \"drawing\"))
			leSetLayerVisible(list(\"METAL6\" \"drawing\") t)
			leSetLayerVisible(list(\"METAL6\" \"pin\") t)
			leSetLayerVisible(list(\"METAL6\" \"dummy\") t)
			leSetLayerVisible(list(\"VIA56\" \"drawing\") t)
			hiRedraw()")

		list("Shift<Key>`"
			"leSetAllLayerVisible( nil )
			leSetEntryLayer( list(\"POLY1\" \"drawing\"))
			leSetLayerVisible(list(\"POLY1\" \"drawing\") t)
			leSetLayerVisible(list(\"POLY1\" \"dummy\") t)
			leSetLayerVisible(list(\"POLY1\" \"pin\") t)
			leSetLayerVisible(list(\"PIMP\" \"drawing\") t)
			leSetLayerVisible(list(\"NIMP\" \"drawing\") t)
			leSetLayerVisible(list(\"DIFF\" \"drawing\") t)
			leSetLayerVisible(list(\"DIFF\" \"dummy\") t)
			leSetLayerVisible(list(\"CONT\" \"drawing\") t)
			leSetLayerVisible(list(\"NWELL\" \"drawing\") t)
			leSetLayerVisible(list(\"WELLBODY\" \"drawing\") t)
			hiRedraw()")
		list("Shift<key>1"
			"leSetAllLayerVisible( nil )
			leSetEntryLayer( list(\"METAL1\" \"drawing\"))
			leSetLayerVisible(list(\"METAL1\" \"drawing\") t)
			leSetLayerVisible(list(\"METAL1\" \"pin\") t)
			leSetLayerVisible(list(\"METAL1\" \"dummy\") t)
			leSetLayerVisible(list(\"CONT\" \"drawing\") t)
			leSetLayerVisible(list(\"VIA12\" \"drawing\") t)
			hiRedraw()")
		list("Shift<Key>2"
			"leSetAllLayerVisible( nil )
			leSetEntryLayer( list(\"METAL2\" \"drawing\"))
			leSetLayerVisible(list(\"METAL2\" \"drawing\") t)
			leSetLayerVisible(list(\"METAL2\" \"pin\") t)
			leSetLayerVisible(list(\"METAL2\" \"dummy\") t)
			leSetLayerVisible(list(\"VIA12\" \"drawing\") t)
			leSetLayerVisible(list(\"VIA23\" \"drawing\") t)
			hiRedraw()")

		;;; FUN FACT "Shift+3" is not "Shift<Key>3", instead it is "<Key>#"
		list("<Key>#"
			"leSetAllLayerVisible( nil )
			leSetEntryLayer( list(\"METAL3\" \"drawing\"))
			leSetLayerVisible(list(\"METAL3\" \"drawing\") t)
			leSetLayerVisible(list(\"METAL3\" \"pin\") t)
			leSetLayerVisible(list(\"METAL3\" \"dummy\") t)
			leSetLayerVisible(list(\"VIA23\" \"drawing\") t)
			leSetLayerVisible(list(\"VIA34\" \"drawing\") t)
			hiRedraw()")
		list("Shift<Key>4"
			"leSetAllLayerVisible( nil )
			leSetEntryLayer( list(\"METAL4\" \"drawing\"))
			leSetLayerVisible(list(\"METAL4\" \"drawing\") t)
			leSetLayerVisible(list(\"METAL4\" \"pin\") t)
			leSetLayerVisible(list(\"METAL4\" \"dummy\") t)
			leSetLayerVisible(list(\"VIA34\" \"drawing\") t)
			leSetLayerVisible(list(\"VIA45\" \"drawing\") t)
			hiRedraw()")
		list("Shift<Key>5"
			"leSetAllLayerVisible( nil )
			leSetEntryLayer( list(\"METAL5\" \"drawing\"))
			leSetLayerVisible(list(\"METAL5\" \"drawing\") t)
			leSetLayerVisible(list(\"METAL5\" \"pin\") t)
			leSetLayerVisible(list(\"METAL5\" \"dummy\") t)
			leSetLayerVisible(list(\"VIA45\" \"drawing\") t)
			leSetLayerVisible(list(\"VIA56\" \"drawing\") t)
			hiRedraw()")
		list("Shift<Key>6"
			"leSetAllLayerVisible( nil )
			leSetEntryLayer( list(\"METAL6\" \"drawing\"))
			leSetLayerVisible(list(\"METAL6\" \"drawing\") t)
			leSetLayerVisible(list(\"METAL6\" \"pin\") t)
			leSetLayerVisible(list(\"METAL6\" \"dummy\") t)
			leSetLayerVisible(list(\"VIA56\" \"drawing\") t)
			hiRedraw()")
		list("Shift<Key>space"
			"leSetAllLayerVisible( t )
			hiRedraw()")

)) ;; hiSetBindKeys
